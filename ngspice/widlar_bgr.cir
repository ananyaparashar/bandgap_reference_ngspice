* =============================================================
* OP-AMP ASSISTED WIDLAR BANDGAP
* - Widlar core extracts PTAT via delta-VBE across emitter resistor
* - Explicit CTAT + K*PTAT summation for VREF
* =============================================================

.title Widlar BGR (Opamp Assisted)

.subckt opamp INP INN VCC VEE OUT
EERR NERR VEE INP INN 2e5
RP1 NERR NDOM 10K
CP1 NDOM VEE 8P
ROUT NDOM OUT 50
DHI OUT VCC DCL
DLO VEE OUT DCL
.model DCL D(IS=1e-12 RS=1)
.ends opamp

.MODEL QNPN NPN (
+ IS=8E-17 BF=180 VAF=120
+ RB=60 RC=20 RE=0.5
+ CJE=0.45P CJC=0.15P TF=0.25N TR=8N
+ XTB=1.5 EG=1.11 XTI=3
+)

* Supply with AC injection for PSRR
VDDRAW VDDRAW 0 DC 3.3
VAC    VDD    VDDRAW DC 0 AC 1

* RC-filtered local rail improves PSRR/line regulation
RFILT  VDD  VDDL  120
CFILT  VDDL 0     8U

* Widlar PTAT core:
* Op-amp forces NC1 ~= NC2, creating equalized branch conditions.
* Q2 has emitter resistor, so NE2 = delta-VBE (PTAT).
Q1  NC1 NBASE 0    QNPN 1
Q2  NC2 NBASE NE2  QNPN 8
RC1 VDDL NC1  220K
RC2 VDDL NC2  220K
RPTAT NE2 0   4.3K
XEA  NC1 NC2 VDDL 0 NBASE opamp

* CTAT branch (diode-connected BJT)
IREF  VDDL NCTAT DC 5U
Q3    NCTAT NCTAT 0 QNPN 1

* PTAT
EPTAT NPTAT 0 VALUE={ V(NE2)*9.5 }

* CTAT + PTAT summation
ESUM  VREF 0 VALUE={ V(NCTAT) + V(NPTAT) }
ROUTL VREF 0 1MEG
COUT  VREF 0 80P

.ic V(NBASE)=0.72 V(NE2)=0.055 V(NCTAT)=0.64 V(NPTAT)=0.60 V(VREF)=1.24

.control
shell mkdir -p "/Users/ananyaparashar/Desktop/wokring_folder/results"

op
print i(VDDRAW)

echo
echo === TEMPERATURE STABILITY ===
dc temp -40 125 1
meas dc vout_27   find v(vref) at=27
meas dc vout_min  min  v(vref)
meas dc vout_max  max  v(vref)
let tc_ppm = (vout_max - vout_min)/(vout_27*165)*1e6
wrdata /Users/ananyaparashar/Desktop/wokring_folder/results/temp_curve.dat v(vref)
setscale temp
plot v(vref) title "Temperature Stability" xlabel "Temperature (C)" ylabel "VREF (V)"

echo
echo === LINE REGULATION ===
dc vddraw 2.0 5.0 0.01
meas dc vout_2v    find v(vref) at=2.0
meas dc vout_499v  find v(vref) at=4.99
let line_reg_mvv = (vout_499v - vout_2v)/2.99*1e3
wrdata /Users/ananyaparashar/Desktop/wokring_folder/results/line_curve.dat v(vref)
plot v(vref) vs v(vdd) title "Line Regulation" xlabel "VDD (V)" ylabel "VREF (V)"

echo
echo === PSRR ===
ac dec 30 1 100meg
meas ac psrr_1hz    find vdb(vref) at=1
meas ac psrr_1khz   find vdb(vref) at=1k
meas ac psrr_100khz find vdb(vref) at=100k
let psrr_1hz_pos = -psrr_1hz
let psrr_1khz_pos = -psrr_1khz
let psrr_100khz_pos = -psrr_100khz
let psrr_db = -vdb(vref)
wrdata /Users/ananyaparashar/Desktop/wokring_folder/results/psrr_curve.dat psrr_db
plot (-vdb(vref)) title "PSRR" xlabel "Frequency (Hz)" ylabel "PSRR (dB)"

* Generate annotated image plots with values written inside graphs
shell python3 "/Users/ananyaparashar/Desktop/wokring_folder/plot_widlar_results.py"

echo
echo === DONE ===
.endc

.end
