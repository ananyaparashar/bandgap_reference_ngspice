* CLASSIC BANDGAP REFERENCE - 1.25V OUTPUT WITH ANALYSIS
.TEMP 27
.OPTIONS ABSTOL=1e-12 RELTOL=1e-6
.OPTIONS NUMDGT=7

VDD VDD 0 DC 3.3

* Classic bandgap configuration with op-amp
Q1 N1 N1 0 QNPN 1
Q2 N2 N1 0 QNPN 8

* Equal currents through both branches
R1 VDD N3 12K
R2 VDD N4 12K

* Op-amp to force V(N3) = V(N4)
EOPAMP N5 0 N4 N3 1e6

* Current mirror
M1 N3 N5 VDD VDD PMOS W=20U L=1U
M2 N4 N5 VDD VDD PMOS W=20U L=1U

* Bandgap output
R3 N4 VBGR 11K
R4 VBGR 0 4K

.MODEL QNPN NPN(IS=1E-16 BF=100)
.MODEL PMOS PMOS (VTO=-0.7 KP=50U LAMBDA=0.05)

*** TEMPERATURE STABILITY ***
.DC TEMP -40 125 2

*** SUPPLY SENSITIVITY ***
.DC VDD 2.7 3.6 0.1

*** TRANSIENT STARTUP ***
.TRAN 0.1U 100U UIC

*** AC ANALYSIS FOR PSRR ***
.AC DEC 10 1 10MEG

* Measurements for Stability Analysis
.MEASURE DC VBG_27 FIND V(VBGR) AT=27
.MEASURE DC VBG_MIN MIN V(VBGR)
.MEASURE DC VBG_MAX MAX V(VBGR)
.MEASURE DC TEMP_COEFF PARAM (VBG_MAX-VBG_MIN)/(125-(-40))/1.25*1e6

* Supply Sensitivity Measurements
.MEASURE DC VBG_2P7 FIND V(VBGR) WHEN VDD=2.7
.MEASURE DC VBG_3P6 FIND V(VBGR) WHEN VDD=3.6
.MEASURE DC LINE_REG PARAM (VBG_3P6-VBG_2P7)/(3.6-2.7)*1000

* PSRR Measurements
.MEASURE AC PSRR_DC FIND VDB(VBGR) AT=1
.MEASURE AC PSRR_100K FIND VDB(VBGR) AT=100K

* Print Results
.PRINT DC V(VBGR) V(N3) V(N4)
.PRINT TRAN V(VBGR) V(VDD)
.PRINT AC VDB(VBGR)

.END
